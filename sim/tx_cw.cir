* Continuous-wave transmit (split mode / Doppler): one element driven at 40 kHz without stop.
* Channel exported from kicad/channel.kicad_sch. Steady state averaged over 4.1-5.9 ms (the element settles within about 1 ms).
* Element current = I(R101) - I(R102) - I(R103) (drive in, minus bleed and limiter).
.include gen/channel.cir
.param ECHO_AC=0 QM=20 fs=40k VDRV=15
.func echo(t)=0
VP VP5A 0 5
VN VN5A 0 -5
Vlog lg 0 PULSE(0 1 10u 10n 10n {0.5/fs-10n} {1/fs})
Binv lgn 0 V=1-V(lg)
Vdd vdd 0 {VDRV}
S1 vdd DRV_OUT lg 0 SWH
S2 DRV_OUT 0 lgn 0 SWL
.model SWH SW(Ron=5 Roff=1G Vt=0.5 Vh=0.01)
.model SWL SW(Ron=0.4 Roff=1G Vt=0.5 Vh=0.01)
Radc RX_OUT 0 1Meg
Cadc RX_OUT 0 5p
.save V(XD) V(LIM) V(DRV_OUT) V(DRV) I(Vdd) I(R101) I(R102) I(R103)
.tran 0 6m 0 20n
.meas TRAN i_vdrv AVG -I(Vdd) FROM 4.1m TO 5.9m
.meas TRAN p_rdrv AVG V(DRV_OUT,DRV)*I(R101) FROM 4.1m TO 5.9m
.meas TRAN p_rlim AVG V(XD,LIM)*I(R103) FROM 4.1m TO 5.9m
.meas TRAN p_bleed AVG V(XD)*I(R102) FROM 4.1m TO 5.9m
.meas TRAN p_elem AVG V(XD)*(I(R101)-I(R102)-I(R103)) FROM 4.1m TO 5.9m
.meas TRAN i_clamp AVG abs(I(R103)) FROM 4.1m TO 5.9m
.meas TRAN xd_pp PP V(XD) FROM 4.1m TO 5.9m
.end
