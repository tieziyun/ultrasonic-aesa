* RX chain noise at the ADC pin (channel exported from kicad/channel.kicad_sch).
* Includes the element's own Rm, every resistor and the OPA1678 noise model.
* sim/run.py refers it to the element by dividing by the gain from rx_chain.
.include gen/channel.cir
.param ECHO_AC=0 QM=20
.func echo(t)=0
VP VP5A 0 5
VN VN5A 0 -5
Rdrv_on DRV_OUT 0 0.4
Radc RX_OUT 0 1Meg
Cadc RX_OUT 0 5p
.noise V(RX_OUT) VP dec 200 1k 1Meg
.end
