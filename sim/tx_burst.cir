* TX burst on one channel, then listen on the same element (blind time / recovery).
* Channel exported from kicad/channel.kicad_sch. UCC27524 half modelled as a 15 V push-pull
* (5 ohm pull-up, 0.4 ohm pull-down, 10 ns edges). 8 cycles at 40 kHz from t = 0.1 ms.
.include gen/channel.cir
.param ECHO_AC=0 QM=20 fs=40k VDRV=15 NCYC=8
.func echo(t)=0
VP VP5A 0 5
VN VN5A 0 -5
Vlog lg 0 PULSE(0 1 0.1m 10n 10n {0.5/fs-10n} {1/fs} {NCYC})
Binv lgn 0 V=1-V(lg)
Vdd vdd 0 {VDRV}
S1 vdd DRV_OUT lg 0 SWH
S2 DRV_OUT 0 lgn 0 SWL
.model SWH SW(Ron=5 Roff=1G Vt=0.5 Vh=0.01)
.model SWL SW(Ron=0.4 Roff=1G Vt=0.5 Vh=0.01)
Radc RX_OUT 0 1Meg
Cadc RX_OUT 0 5p
.save V(XD) V(LIM) V(RX_OUT) V(DRV_OUT) V(DRV) I(R101) I(R103)
.tran 0 4m 0 20n
.meas TRAN xd_pk MAX V(XD) FROM 0.1m TO 0.35m
.meas TRAN xd_min MIN V(XD) FROM 0.1m TO 0.35m
.meas TRAN i_pk MAX I(R101) FROM 0.1m TO 0.35m
.meas TRAN lim_pk MAX V(LIM) FROM 0.1m TO 0.35m
.meas TRAN lim_min MIN V(LIM) FROM 0.1m TO 0.35m
.meas TRAN p_rlim AVG V(XD,LIM)*I(R103) FROM 0.1m TO 0.3m
.meas TRAN p_rdrv AVG V(DRV_OUT,DRV)*I(R101) FROM 0.1m TO 0.3m
.meas TRAN adc_pk MAX V(RX_OUT) FROM 0.1m TO 0.35m
.meas TRAN t_1v    WHEN abs(V(RX_OUT))=1    FALL=last
.meas TRAN t_100mv WHEN abs(V(RX_OUT))=0.1  FALL=last
.meas TRAN t_10mv  WHEN abs(V(RX_OUT))=0.01 FALL=last
.end
